** Profile: "SCHEMATIC1-differential amplifier test"  [ c:\users\msdl3\desktop\orcad file\80db_lidar\asd-PSpiceFiles\SCHEMATIC1\differential amplifier test.sim ]

** Creating circuit file "differential amplifier test.cir"
** WARNING: THIS AUTOMATICALLY GENERATED FILE MAY BE OVERWRITTEN BY SUBSEQUENT SIMULATIONS

*Libraries:
* Profile Libraries :
* Local Libraries :
* From [PSPICE NETLIST] section of C:\Users\MSDL3\AppData\Roaming\SPB_Data\cdssetup\OrCAD_PSpice\17.2.0\PSpice.ini file:
.lib "C:\Cadence\SPB_17.2\tools\capture\library\pspice\opa855_pspice\opa855_a.lib"
.lib "C:\Cadence\SPB_17.2\tools\capture\library\pspice\sboc036d\opa695_a.lib"
.lib "C:\Cadence\SPB_17.2\tools\capture\library\pspice\opa892\opa892.lib"
.lib "nom.lib"

*Analysis directives:
.TRAN  0 30ns 0
.OPTIONS ADVCONV
.PROBE64 V(alias(*)) I(alias(*)) W(alias(*)) D(alias(*)) NOISE(alias(*))
.INC "..\SCHEMATIC1.net"

.END
