** Profile: "SCHEMATIC1-ac_sweep"  [ C:\Users\a0232073\Desktop\GWL_Models\OPA855\AppendScript\opa855_pspice\opa855_pspice-pspicefiles\schematic1\ac_sweep.sim ]

** Creating circuit file "ac_sweep.cir"
** WARNING: THIS AUTOMATICALLY GENERATED FILE MAY BE OVERWRITTEN BY SUBSEQUENT SIMULATIONS

*Libraries:
* Profile Libraries :
.INC "C:\Users\a0232073\Desktop\GWL_Models\OPA855\AppendScript\opa855_pspice\opa855_pspice-pspicefiles\schematic1\ac_sweep\ac_sweep"
+ "_profile.inc"
* Local Libraries :
* From [PSPICE NETLIST] section of C:\SPB_Data\cdssetup\OrCAD_PSpiceTIPSpice_Install\17.4.0\PSpice.ini file:
.lib "nom_pspti.lib"
.lib "nom.lib"

*Analysis directives:
.AC DEC 31 1k 100G
.OPTIONS ADVCONV
.PROBE64 N([OUT])
.INC "..\SCHEMATIC1.net"

.END
