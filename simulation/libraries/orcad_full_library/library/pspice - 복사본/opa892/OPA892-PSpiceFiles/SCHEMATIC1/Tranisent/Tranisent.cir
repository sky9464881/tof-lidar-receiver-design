** Profile: "SCHEMATIC1-Tranisent"  [ C:\Users\a0488507\Documents\TI_Models\PSpiceFiles\OPA892-PSpiceFiles\SCHEMATIC1\Tranisent.sim ]

** Creating circuit file "Tranisent.cir"
** WARNING: THIS AUTOMATICALLY GENERATED FILE MAY BE OVERWRITTEN BY SUBSEQUENT SIMULATIONS

*Libraries:
* Profile Libraries :
* Local Libraries :
.LIB "../../../OPA892.lib"
* From [PSPICE NETLIST] section of C:\cds_spb_home\cdssetup\OrCAD_PSpiceTIPSpice_Install\17.4.0\PSpice.ini file:
.lib "nom_pspti.lib"
.lib "nom.lib"

*Analysis directives:
.TRAN  0 5u 0 5E-11
.OPTIONS ADVCONV
.OPTIONS FILEMODELSEARCH
.PROBE64 N([N00357])
.PROBE64 N([N00673])
.INC "..\SCHEMATIC1.net"

.END
