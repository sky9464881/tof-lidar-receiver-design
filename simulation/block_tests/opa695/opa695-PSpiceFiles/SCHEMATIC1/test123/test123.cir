** Profile: "SCHEMATIC1-test123"  [ C:\Users\sky94\AppData\Roaming\SPB_Data\cdssetup\workspace\projects\opa695\opa695-pspicefiles\schematic1\test123.sim ]

** Creating circuit file "test123.cir"
** WARNING: THIS AUTOMATICALLY GENERATED FILE MAY BE OVERWRITTEN BY SUBSEQUENT SIMULATIONS

*Libraries:
* Profile Libraries :
* Local Libraries :
* From [PSPICE NETLIST] section of C:\Users\sky94\AppData\Roaming\SPB_Data\cdssetup\OrCAD_PSpice\24.1.0\PSpice.ini file:
.lib "C:\Users\sky94\OneDrive\문서\카카오톡 받은 파일\pspice추가_라이브러리\pspice추가_라이브러리\OPA277\OPAx277.LIB"
.lib "C:\Users\sky94\OneDrive\문서\카카오톡 받은 파일\pspice추가_라이브러리\pspice추가_라이브러리\TVL3604\tlv3604.lib"
.lib "C:\Users\sky94\OneDrive\문서\카카오톡 받은 파일\pspice추가_라이브러리\pspice추가_라이브러리\opa855_pspice\opa855_a.lib"
.lib "C:\Users\sky94\OneDrive\문서\카카오톡 받은 파일\pspice추가_라이브러리\pspice추가_라이브러리\opa695\opa695_a.lib"
.lib "nom.lib"

*Analysis directives:
.TRAN  0 0.05u 0 0.0001m
.OPTIONS ADVCONV
.PROBE64 V(alias(*)) I(alias(*)) W(alias(*)) D(alias(*)) NOISE(alias(*))
.INC "..\SCHEMATIC1.net"

.END
