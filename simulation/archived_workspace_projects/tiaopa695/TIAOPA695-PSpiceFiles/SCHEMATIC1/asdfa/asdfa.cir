** Profile: "SCHEMATIC1-asdfa"  [ c:\users\user\appdata\roaming\spb_data\cdssetup\workspace\projects\tiaopa695\TIAOPA695-PSpiceFiles\SCHEMATIC1\asdfa.sim ]

** Creating circuit file "asdfa.cir"
** WARNING: THIS AUTOMATICALLY GENERATED FILE MAY BE OVERWRITTEN BY SUBSEQUENT SIMULATIONS

*Libraries:
* Profile Libraries :
* Local Libraries :
* From [PSPICE NETLIST] section of C:\Users\user\AppData\Roaming\SPB_Data\cdssetup\OrCAD_PSpice\24.1.0\PSpice.ini file:
.lib "C:\Cadence\OrCADX_24.1\tools\capture\library\nom.lib"
.lib "C:\Cadence\OrCADX_24.1\OpenAccess\lib\x64\opt\oaDebugCDS.lib"
.lib "C:\Cadence\OrCADX_24.1\tools\capture\library\opa855_a.lib"
.lib "C:\Cadence\OrCADX_24.1\tools\capture\library\OPA858.lib"
.lib "C:\Cadence\OrCADX_24.1\tools\capture\library\opa695_a.lib"
.lib "C:\Cadence\OrCADX_24.1\tools\capture\library\opa856_a.lib"
.lib "C:\Cadence\OrCADX_24.1\tools\capture\library\tlv3604.lib"
.lib "C:\Cadence\OrCADX_24.1\tools\capture\library\OPAx277.LIB"

*Analysis directives:
.TRAN  0 20n 0
.STEP LIN PARAM IVar 30u 6m 300u
.OPTIONS ADVCONV
.PROBE64 V(alias(*)) I(alias(*)) W(alias(*)) D(alias(*)) NOISE(alias(*))
.INC "..\SCHEMATIC1.net"

.END
